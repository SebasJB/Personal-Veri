/* SystemRDL 2.0 — generado a partir del UVM_RAL.sv compartido.
 * Notas:
 * - Se conservan los mismos nombres de registros e incluso los nombres de campos (SIZE, OFFSET, CLR, etc.).
 * - El mapa usa little-endian y un ancho de acceso de 64 bits como en create_map(..., 8, UVM_LITTLE_ENDIAN).
 * - Los campos marcados W1C en UVM se modelan con onwrite = woclr (SystemRDL 2.0).
 * - En UVM todos los fields aparecen con individually_accessible(1); SystemRDL no tiene una propiedad estándar,
 *   así que lo documentamos con comentarios junto a cada field.
 */

addrmap top_reg_block {
  littleendian = true;
  default regwidth = 32;
  default accesswidth = 64; // create_map byte_width = 8

  // CTRL @ 0x0000
  reg CTRL {
    // individually_accessible: true
    field { sw = rw; } SIZE[2:0]   = 1;
    field { sw = r;  } RSV0[7:3]   = 0;

    // individually_accessible: true
    field { sw = rw; } OFFSET[9:8] = 0;
    field { sw = r;  } RSV1[15:10] = 0;

    // individually_accessible: true
    field { sw = rw; } CLR[16:16]  = 0;
    field { sw = r;  } RSV2[31:17] = 0;
  };
  CTRL CTRL @ 0x0000;

  // STATUS @ 0x000C
  reg STATUS {
    // individually_accessible: true
    field { sw = r; } CNT_DROP[2:0]  = 1;
    field { sw = r; } RSV0[7:3]      = 0;

    // individually_accessible: true
    field { sw = r; } RX_LVL[9:8]    = 0;
    field { sw = r; } RSV1[15:10]    = 0;

    // individually_accessible: true
    field { sw = r; } TX_LVL[16:16]  = 0;
    field { sw = r; } RSV2[31:17]    = 0;
  };
  STATUS STATUS @ 0x000C;

  // IRQEN @ 0x00F0
  reg IRQEN {
    // individually_accessible: true
    field { sw = rw; } RX_FIFO_EMPTY[0] = 0;
    // individually_accessible: true
    field { sw = rw; } RX_FIFO_FULL[1]  = 0;
    // individually_accessible: true
    field { sw = rw; } TX_FIFO_EMPTY[2] = 0;
    // individually_accessible: true
    field { sw = rw; } TX_FIFO_FULL[3]  = 0;
    // individually_accessible: true
    field { sw = rw; } MAX_DROP[4]      = 0;

    field { sw = r; } RSV[31:5]         = 0;
  };
  IRQEN IRQEN @ 0x00F0;

  // IRQ @ 0x00F4
  reg IRQ {
    // individually_accessible: true
    field { sw = rw; onwrite = woclr; volatile = true; } RX_FIFO_EMPTY[0] = 0;
    // individually_accessible: true
    field { sw = rw; onwrite = woclr; volatile = true; } RX_FIFO_FULL[1]  = 0;
    // individually_accessible: true
    field { sw = rw; onwrite = woclr; volatile = true; } TX_FIFO_EMPTY[2] = 0;
    // individually_accessible: true
    field { sw = rw; onwrite = woclr; volatile = true; } TX_FIFO_FULL[3]  = 0;
    // individually_accessible: true
    field { sw = rw; onwrite = woclr; volatile = true; } MAX_DROP[4]      = 0;

    field { sw = r; } RSV[31:5] = 0;
  };
  IRQ IRQ @ 0x00F4;
};
